* Full-Wave Bridge Rectifier with Modified Filter Capacitor
V1 1 0 SIN(0 100 50)
D1 1 2 D1N4002
D2 0 2 D1N4002
D3 3 1 D1N4002
D4 3 0 D1N4002
C1 2 3 50U
R1 2 3 10k
.MODEL D1N4002 D
.TRAN 10US 300MS
.PROBE
.END
