* Common-base output characteristic (NPN 2N3904)
* I_E = 1 mA
IEE e 0 0.001
Q1 c 0 e Q2N3904
VCB c 0 0
.MODEL Q2N3904 NPN(IS=6.734F XTI=3 EG=1.11 VAF=74.03 BF=416.4 NE=1.259
+ ISE=6.734F IKF=.06678 XTB=1.5 BR=.7371 NC=2 ISC=0 IKR=0 RC=1
+ CJC=3.638P MJC=.3085 VJC=.75 FC=.5 CJE=4.493P MJE=.2593 VJE=.75
+ TR=239.5N TF=301.2P ITF=.4 VTF=4 XTF=2 RB=10)
.SAVE all @q1[ic] @q1[ib] @q1[ie]
.DC VCB -0.75 10 0.05
.PROBE
.END
