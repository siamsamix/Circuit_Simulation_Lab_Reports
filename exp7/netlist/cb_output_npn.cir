* Common-base output characteristic (NPN 2N3904)
* inner sweep: VCB (collector supply)   outer sweep: VEE = 0 ... 5 V
* (I_E = (VEE - V_EB)/RE, i.e. roughly 0, 0.4, 1.3, 2.3, 3.3, 4.3 mA)
VCC ncs 0 0
RC ncs c 100
Q1 c 0 e Q2N3904
RE nes e 1k
VEE 0 nes 0
.MODEL Q2N3904 NPN(IS=6.734F XTI=3 EG=1.11 VAF=74.03 BF=416.4 NE=1.259
+ ISE=6.734F IKF=.06678 XTB=1.5 BR=.7371 NC=2 ISC=0 IKR=0 RC=1
+ CJC=3.638P MJC=.3085 VJC=.75 FC=.5 CJE=4.493P MJE=.2593 VJE=.75
+ TR=239.5N TF=301.2P ITF=.4 VTF=4 XTF=2 RB=10)
.SAVE all @q1[ic] @q1[ib] @q1[ie]
.DC VCC -2 12 0.02 VEE 0 5 1
.PROBE
.END
