* Common-collector output characteristic (PNP 2N3906), textbook wiring
* collector = common (ground) node, no collector resistor.
* VBB (-) -> RB -> base, VBB (+) on the collector rail (base at -VBB).
* emitter supply VEE = +VCE feeds the emitter through RE.
* inner sweep: VEE (-0.2 -> 5.2 V = VCE)
* outer sweep: VBB = -6, 14, 34, 54, 74 V as set on the source, i.e. the base supply is
* +6, -14, -34, -54, -74 V (I_B ~ 0, 14, 34, 54, 74 uA)
VEE nes 0 0
RE nes e 1
Q1 0 b e Q2N3906
VBB 0 nbs 0
RB nbs b 1Meg
.MODEL Q2N3906 PNP(IS=1.41F XTI=3 EG=1.11 VAF=18.7 BF=180.7 NE=1.5
+ ISE=0 IKF=80m XTB=1.5 BR=4.977 NC=2 ISC=0 IKR=0 RC=2.5
+ CJC=9.728P MJC=.5776 VJC=.75 FC=.5 CJE=8.063P MJE=.3677 VJE=.75
+ TR=33.42N TF=179.3P ITF=.4 VTF=4 XTF=6 RB=10)
.SAVE all @q1[ic] @q1[ib] @q1[ie]
.DC VEE -0.2 5.2 0.025 VBB -6 74 20
.PROBE
.END
