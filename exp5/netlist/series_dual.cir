* Dual clipper in series
V1 1 0 SIN(0 80 50)
D1 1 4 D1N4002
R1 4 3 100
V2 0 3 30
D2 2 4 D1N4002
R2 2 5 1Meg
V3 5 0 50
.model D1N4002 D(Is=14.11n Rs=33.89m N=1.984 Ikf=94.81 Xti=3 Eg=1.11 Cjo=51.17p M=.2762 Vj=.3905 Fc=.5 Isr=100.0p Nr=2 Bv=100.1 Ibv=10 Tt=4.761u)
.tran 10u 80m
.print tran v(1) v(2)
.end
